| / 7\'7
| \ \   Xilinx Inc.
| / /
| \_\/.\   IBIS Models for ZYNQ7 IO
[IBIS ver]   4.2
[File name]   impl_1.ibs
[File Rev]   2.8
[Date]   Wed December 19 14:55:59 2018
[Source]   Derived from spice models, rev1.0, using
   hspice 2010.03-ENG2
[Notes]   Xilinx IBIS file for ZYNQ7 I/O standards.
   All models are preliminary.
   The version of IBISCHK used is ibischk5.
   Ibis models were generated using S2IBIS3.
[Disclaimer] The data in this file is derived from SPICE simulations using
                 modeling information extracted from the target process.
                 A great deal of care has been taken to provide information
                 that is accurate. This model has been verified by actual silicon
                 measurement.
[Copyright]   Copyright 2012-2016, Xilinx Inc., All rights reserved
|   Component ZYNQ7
[Component]   ZYNQ
[Manufacturer]   Xilinx Inc.
[Package]
|CLG400
|variable   typ   min   max
R_pkg   409.3m   130.9m   730.5m
L_pkg   8.10nH   2.71nH   14.76nH
C_pkg   1.31pF   0.33pF   2.90pF
[Pin]   signal_name   model_name  R_pin  L_pin  C_pin
A1   DDR_dm[0]   SSTL15_DCI_F_PSDDR_MS
A2   DDR_dq[2]   SSTL15_DCI_F_PSDDR_MS
A3   VCCO_DDR_502   POWER
A4   DDR_dq[3]   SSTL15_DCI_F_PSDDR_MS
A5   FIXED_IO_mio[6]   LVCMOS33_S_8_PSMIO
A6   FIXED_IO_mio[5]   LVCMOS33_S_8_PSMIO
A7   FIXED_IO_mio[1]   LVCMOS33_S_8_PSMIO
A8   GND   GND
A9   FIXED_IO_mio[43]   LVCMOS18_S_8_PSMIO
A10   FIXED_IO_mio[37]   LVCMOS18_S_8_PSMIO
A11   FIXED_IO_mio[36]   LVCMOS18_S_8_PSMIO
A12   FIXED_IO_mio[34]   LVCMOS18_S_8_PSMIO
A13   VCCO_MIO1_501   POWER
A14   FIXED_IO_mio[32]   LVCMOS18_S_8_PSMIO
A15   FIXED_IO_mio[26]   LVCMOS18_S_8_PSMIO
A16   FIXED_IO_mio[24]   LVCMOS18_S_8_PSMIO
A17   FIXED_IO_mio[20]   LVCMOS18_S_8_PSMIO
A18   GND   GND
A19   FIXED_IO_mio[16]   LVCMOS18_S_8_PSMIO
A20   IO_L2N_T0_AD8N_35   NC
B1   GND   GND
B2   DDR_dqs_n[0]   SSTL15_DCI_F_PSDDR_MS
B3   DDR_dq[1]   SSTL15_DCI_F_PSDDR_MS
B4   DDR_reset_n   SSTL15_F_PSDDR
B5   FIXED_IO_mio[9]   LVCMOS33_S_8_PSMIO
B6   VCCO_MIO0_500   POWER
B7   FIXED_IO_mio[4]   LVCMOS33_S_8_PSMIO
B8   FIXED_IO_mio[2]   LVCMOS33_S_8_PSMIO
B9   FIXED_IO_mio[51]   LVCMOS18_S_8_PSMIO
B10   FIXED_IO_ps_srstb   NC
B11   GND   GND
B12   FIXED_IO_mio[48]   LVCMOS18_S_8_PSMIO
B13   FIXED_IO_mio[50]   LVCMOS18_S_8_PSMIO
B14   FIXED_IO_mio[47]   LVCMOS18_S_8_PSMIO
B15   FIXED_IO_mio[45]   LVCMOS18_S_8_PSMIO
B16   VCCO_MIO1_501   POWER
B17   FIXED_IO_mio[22]   LVCMOS18_S_8_PSMIO
B18   FIXED_IO_mio[18]   LVCMOS18_S_8_PSMIO
B19   IO_L2P_T0_AD8P_35   NC
B20   IO_L1N_T0_AD0N_35   NC
C1   DDR_dq[6]   SSTL15_DCI_F_PSDDR_MS
C2   DDR_dqs_p[0]   SSTL15_DCI_F_PSDDR_MS
C3   DDR_dq[0]   SSTL15_DCI_F_PSDDR_MS
C4   GND   GND
C5   FIXED_IO_mio[14]   LVCMOS33_S_8_PSMIO
C6   FIXED_IO_mio[11]   LVCMOS33_S_8_PSMIO
C7   FIXED_IO_ps_porb   NC
C8   FIXED_IO_mio[15]   LVCMOS33_S_8_PSMIO
C9   GND   GND
C10   FIXED_IO_mio[52]   LVCMOS18_S_8_PSMIO
C11   FIXED_IO_mio[53]   LVCMOS18_S_8_PSMIO
C12   FIXED_IO_mio[49]   LVCMOS18_S_8_PSMIO
C13   FIXED_IO_mio[29]   LVCMOS18_S_8_PSMIO
C14   GND   GND
C15   FIXED_IO_mio[30]   LVCMOS18_S_8_PSMIO
C16   FIXED_IO_mio[28]   LVCMOS18_S_8_PSMIO
C17   FIXED_IO_mio[41]   LVCMOS18_S_8_PSMIO
C18   FIXED_IO_mio[39]   LVCMOS18_S_8_PSMIO
C19   VCCO_35   POWER
C20   IO_L1P_T0_AD0P_35   NC
D1   DDR_dq[5]   SSTL15_DCI_F_PSDDR_MS
D2   VCCO_DDR_502   POWER
D3   DDR_dq[4]   SSTL15_DCI_F_PSDDR_MS
D4   DDR_addr[13]   SSTL15_S_PSDDR
D5   FIXED_IO_mio[8]   LVCMOS33_S_8_PSMIO
D6   FIXED_IO_mio[3]   LVCMOS33_S_8_PSMIO
D7   VCCO_MIO0_500   POWER
D8   FIXED_IO_mio[7]   LVCMOS33_S_8_PSMIO
D9   FIXED_IO_mio[12]   LVCMOS33_S_8_PSMIO
D10   FIXED_IO_mio[19]   LVCMOS18_S_8_PSMIO
D11   FIXED_IO_mio[23]   LVCMOS18_S_8_PSMIO
D12   VCCO_MIO1_501   POWER
D13   FIXED_IO_mio[27]   LVCMOS18_S_8_PSMIO
D14   FIXED_IO_mio[40]   LVCMOS18_S_8_PSMIO
D15   FIXED_IO_mio[33]   LVCMOS18_S_8_PSMIO
D16   FIXED_IO_mio[46]   LVCMOS18_S_8_PSMIO
D17   GND   GND
D18   IO_L3N_T0_DQS_AD1N_35   NC
D19   IO_L4P_T0_35   NC
D20   IO_L4N_T0_35   NC
E1   DDR_dq[7]   SSTL15_DCI_F_PSDDR_MS
E2   DDR_dq[8]   SSTL15_DCI_F_PSDDR_MS
E3   DDR_dq[9]   SSTL15_DCI_F_PSDDR_MS
E4   DDR_addr[12]   SSTL15_S_PSDDR
E5   VCCO_DDR_502   POWER
E6   FIXED_IO_mio[0]   LVCMOS33_S_8_PSMIO
E7   FIXED_IO_ps_clk   NC
E8   FIXED_IO_mio[13]   LVCMOS33_S_8_PSMIO
E9   FIXED_IO_mio[10]   LVCMOS33_S_8_PSMIO
E10   GND   GND
E11   PS_MIO_VREF_501   NC
E12   FIXED_IO_mio[42]   LVCMOS18_S_8_PSMIO
E13   FIXED_IO_mio[38]   LVCMOS18_S_8_PSMIO
E14   FIXED_IO_mio[17]   LVCMOS18_S_8_PSMIO
E15   VCCO_MIO1_501   POWER
E16   FIXED_IO_mio[31]   LVCMOS18_S_8_PSMIO
E17   IO_L3P_T0_DQS_AD1P_35   NC
E18   IO_L5P_T0_AD9P_35   NC
E19   IO_L5N_T0_AD9N_35   NC
E20   GND   GND
F1   DDR_dm[1]   SSTL15_DCI_F_PSDDR_MS
F2   DDR_dqs_n[1]   SSTL15_DCI_F_PSDDR_MS
F3   GND   GND
F4   DDR_addr[14]   SSTL15_S_PSDDR
F5   DDR_addr[10]   SSTL15_S_PSDDR
F6   TDO_0   LVCMOS18_F_12_HR
F7   GND   GND
F8   VCCPAUX   POWER
F9   TCK_0   LVCMOS18_F_12_HR
F10   RSVDGND   GND
F11   VCCBATT_0   LVCMOS18_F_12_HR
F12   FIXED_IO_mio[35]   LVCMOS18_S_8_PSMIO
F13   FIXED_IO_mio[44]   LVCMOS18_S_8_PSMIO
F14   FIXED_IO_mio[21]   LVCMOS18_S_8_PSMIO
F15   FIXED_IO_mio[25]   LVCMOS18_S_8_PSMIO
F16   IO_L6P_T0_35   NC
F17   IO_L6N_T0_VREF_35   NC
F18   VCCO_35   POWER
F19   IO_L15P_T2_DQS_AD12P_35   NC
F20   IO_L15N_T2_DQS_AD12N_35   NC
G1   VCCO_DDR_502   POWER
G2   DDR_dqs_p[1]   SSTL15_DCI_F_PSDDR_MS
G3   DDR_dq[10]   SSTL15_DCI_F_PSDDR_MS
G4   DDR_addr[11]   SSTL15_S_PSDDR
G5   FIXED_IO_ddr_vrn   NC
G6   TDI_0   LVCMOS18_F_12_HR
G7   VCCPINT   POWER
G8   VCCPLL   POWER
G9   VCCPAUX   POWER
G10   GND   GND
G11   VCCBRAM   POWER
G12   GND   GND
G13   VCCINT   POWER
G14   IO_0_35   NC
G15   IO_L19N_T3_VREF_35   NC
G16   GND   GND
G17   IO_L16P_T2_35   NC
G18   IO_L16N_T2_35   NC
G19   IO_L18P_T2_AD13P_35   NC
G20   IO_L18N_T2_AD13N_35   NC
H1   DDR_dq[14]   SSTL15_DCI_F_PSDDR_MS
H2   DDR_dq[13]   SSTL15_DCI_F_PSDDR_MS
H3   DDR_dq[11]   SSTL15_DCI_F_PSDDR_MS
H4   VCCO_DDR_502   POWER
H5   FIXED_IO_ddr_vrp   NC
H6   PS_DDR_VREF0_502   NC
H7   GND   GND
H8   VCCPAUX   POWER
H9   GND   GND
H10   VCCBRAM   POWER
H11   GND   GND
H12   VCCINT   POWER
H13   GND   GND
H14   VCCO_35   POWER
H15   IO_L19P_T3_35   NC
H16   IO_L13P_T2_MRCC_35   NC
H17   IO_L13N_T2_MRCC_35   NC
H18   IO_L14N_T2_AD4N_SRCC_35   NC
H19   GND   GND
H20   IO_L17N_T2_AD5N_35   NC
J1   DDR_dq[15]   SSTL15_DCI_F_PSDDR_MS
J2   GND   GND
J3   DDR_dq[12]   SSTL15_DCI_F_PSDDR_MS
J4   DDR_addr[9]   SSTL15_S_PSDDR
J5   DDR_ba[2]   SSTL15_S_PSDDR
J6   TMS_0   LVCMOS18_F_12_HR
J7   VCCPINT   POWER
J8   GND   GND
J9   VCCADC_0   NC
J10   GNDADC_0   NC
J11   VCCAUX   POWER
J12   GND   GND
J13   VCCINT   POWER
J14   IO_L20N_T3_AD6N_35   NC
J15   IO_25_35   NC
J16   IO_L24N_T3_AD15N_35   NC
J17   VCCO_35   POWER
J18   IO_L14P_T2_AD4P_SRCC_35   NC
J19   IO_L10N_T1_AD11N_35   NC
J20   IO_L17P_T2_AD5P_35   NC
K1   DDR_addr[8]   SSTL15_S_PSDDR
K2   DDR_addr[1]   SSTL15_S_PSDDR
K3   DDR_addr[3]   SSTL15_S_PSDDR
K4   DDR_addr[7]   SSTL15_S_PSDDR
K5   GND   GND
K6   VCCO_0   POWER
K7   GND   GND
K8   VCCPAUX   POWER
K9   VP_0   NC
K10   VREFN_0   NC
K11   GND   GND
K12   VCCINT   POWER
K13   GND   GND
K14   IO_L20P_T3_AD6P_35   NC
K15   GND   GND
K16   IO_L24P_T3_AD15P_35   NC
K17   IO_L12P_T1_MRCC_35   NC
K18   IO_L12N_T1_MRCC_35   NC
K19   IO_L10P_T1_AD11P_35   NC
K20   VCCO_35   POWER
L1   DDR_addr[5]   SSTL15_S_PSDDR
L2   DDR_ck_p   SSTL15_F_PSDDR
L3   VCCO_DDR_502   POWER
L4   DDR_addr[6]   SSTL15_S_PSDDR
L5   DDR_ba[0]   SSTL15_S_PSDDR
L6   PROGRAM_B_0   LVCMOS18_F_12_HR
L7   VCCPINT   POWER
L8   GND   GND
L9   VREFP_0   NC
L10   VN_0   NC
L11   VCCAUX   POWER
L12   GND   GND
L13   VCCINT   POWER
L14   IO_L22P_T3_AD7P_35   NC
L15   IO_L22N_T3_AD7N_35   NC
L16   IO_L11P_T1_SRCC_35   NC
L17   IO_L11N_T1_SRCC_35   NC
L18   GND   GND
L19   IO_L9P_T1_DQS_AD3P_35   NC
L20   IO_L9N_T1_DQS_AD3N_35   NC
M1   GND   GND
M2   DDR_ck_n   SSTL15_F_PSDDR
M3   DDR_addr[2]   SSTL15_S_PSDDR
M4   DDR_addr[4]   SSTL15_S_PSDDR
M5   DDR_we_n   SSTL15_S_PSDDR
M6   CFGBVS_0   LVCMOS18_F_12_HR
M7   GND   GND
M8   VCCPAUX   POWER
M9   DXP_0   NC
M10   DXN_0   NC
M11   GND   GND
M12   VCCINT   POWER
M13   GND   GND
M14   IO_L23P_T3_35   NC
M15   IO_L23N_T3_35   NC
M16   VCCO_35   POWER
M17   IO_L8P_T1_AD10P_35   NC
M18   IO_L8N_T1_AD10N_35   NC
M19   IO_L7P_T1_AD2P_35   NC
M20   IO_L7N_T1_AD2N_35   NC
N1   DDR_cs_n   SSTL15_S_PSDDR
N2   DDR_addr[0]   SSTL15_S_PSDDR
N3   DDR_cke   SSTL15_S_PSDDR
N4   GND   GND
N5   DDR_odt   SSTL15_S_PSDDR
N6   RSVDVCC3   NC
N7   VCCPINT   POWER
N8   GND   GND
N9   VCCAUX   POWER
N10   GND   GND
N11   VCCAUX   POWER
N12   GND   GND
N13   VCCINT   POWER
N14   GND   GND
N15   IO_L21P_T3_DQS_AD14P_35   NC
N16   IO_L21N_T3_DQS_AD14N_35   NC
N17   IO_L23P_T3_34   NC
N18   IO_L13P_T2_MRCC_34   NC
N19   VCCO_34   POWER
N20   IO_L14P_T2_SRCC_34   NC
P1   DDR_dq[16]   SSTL15_DCI_F_PSDDR_MS
P2   VCCO_DDR_502   POWER
P3   DDR_dq[17]   SSTL15_DCI_F_PSDDR_MS
P4   DDR_ras_n   SSTL15_S_PSDDR
P5   DDR_cas_n   SSTL15_S_PSDDR
P6   PS_DDR_VREF1_502   NC
P7   GND   GND
P8   VCCPINT   POWER
P9   GND   GND
P10   VCCAUX   POWER
P11   GND   GND
P12   VCCINT   POWER
P13   GND   GND
P14   IO_L6P_T0_34   NC
P15   IO_L24P_T3_34   NC
P16   IO_L24N_T3_34   NC
P17   GND   GND
P18   IO_L23N_T3_34   NC
P19   IO_L13N_T2_MRCC_34   NC
P20   IO_L14N_T2_SRCC_34   NC
R1   DDR_dq[19]   SSTL15_DCI_F_PSDDR_MS
R2   DDR_dqs_p[2]   SSTL15_DCI_F_PSDDR_MS
R3   DDR_dq[18]   SSTL15_DCI_F_PSDDR_MS
R4   DDR_ba[1]   SSTL15_S_PSDDR
R5   VCCO_DDR_502   POWER
R6   RSVDVCC2   NC
R7   VCCPINT   POWER
R8   GND   GND
R9   VCCAUX   POWER
R10   INIT_B_0   LVCMOS18_F_12_HR
R11   DONE_0   LVCMOS18_F_12_HR
R12   GND   GND
R13   VCCINT   POWER
R14   IO_L6N_T0_VREF_34   NC
R15   VCCO_34   POWER
R16   IO_L19P_T3_34   NC
R17   IO_L19N_T3_VREF_34   NC
R18   IO_L20N_T3_34   NC
R19   IO_0_34   NC
R20   GND   GND
T1   DDR_dm[2]   SSTL15_DCI_F_PSDDR_MS
T2   DDR_dqs_n[2]   SSTL15_DCI_F_PSDDR_MS
T3   GND   GND
T4   DDR_dq[20]   SSTL15_DCI_F_PSDDR_MS
T6   RSVDVCC1   NC
T7   GND   GND
T8   VCCO_13   POWER
T10   IO_L1N_T0_34   NC
T11   IO_L1P_T0_34   NC
T12   IO_L2P_T0_34   NC
T13   GND   GND
T14   IO_L5P_T0_34   NC
T15   IO_L5N_T0_34   NC
T16   IO_L9P_T1_DQS_34   NC
T17   IO_L20P_T3_34   NC
T18   VCCO_34   POWER
T19   IO_25_34   NC
T20   IO_L15P_T2_DQS_34   NC
U1   VCCO_DDR_502   POWER
U2   DDR_dq[22]   SSTL15_DCI_F_PSDDR_MS
U3   DDR_dq[23]   SSTL15_DCI_F_PSDDR_MS
U4   DDR_dq[21]   SSTL15_DCI_F_PSDDR_MS
U6   GND   GND
U11   VCCO_13   POWER
U12   IO_L2N_T0_34   NC
U13   PUDC_B   LVCMOS25_F_8_HR
U14   IO_L11P_T1_SRCC_34   NC
U15   IO_L11N_T1_SRCC_34   NC
U16   GND   GND
U17   IO_L9N_T1_DQS_34   NC
U18   IO_L12P_T1_MRCC_34   NC
U19   IO_L12N_T1_MRCC_34   NC
U20   IO_L15N_T2_DQS_34   NC
V1   DDR_dq[24]   SSTL15_DCI_F_PSDDR_MS
V2   DDR_dq[30]   SSTL15_DCI_F_PSDDR_MS
V3   DDR_dq[31]   SSTL15_DCI_F_PSDDR_MS
V4   VCCO_DDR_502   POWER
V9   GND   GND
V12   IO_L4P_T0_34   NC
V13   IO_L3N_T0_DQS_34   NC
V14   VCCO_34   POWER
V15   IO_L10P_T1_34   NC
V16   IO_L18P_T2_34   NC
V17   IO_L21P_T3_DQS_34   NC
V18   IO_L21N_T3_DQS_34   NC
V19   GND   GND
V20   IO_L16P_T2_34   NC
W1   DDR_dq[26]   SSTL15_DCI_F_PSDDR_MS
W2   GND   GND
W3   DDR_dq[29]   SSTL15_DCI_F_PSDDR_MS
W4   DDR_dqs_n[3]   SSTL15_DCI_F_PSDDR_MS
W5   DDR_dqs_p[3]   SSTL15_DCI_F_PSDDR_MS
W7   VCCO_13   POWER
W12   GND   GND
W13   IO_L4N_T0_34   NC
W14   IO_L8P_T1_34   NC
W15   IO_L10N_T1_34   NC
W16   IO_L18N_T2_34   NC
W17   VCCO_34   POWER
W18   IO_L22P_T3_34   NC
W19   IO_L22N_T3_34   NC
W20   IO_L16N_T2_34   NC
Y1   DDR_dm[3]   SSTL15_DCI_F_PSDDR_MS
Y2   DDR_dq[28]   SSTL15_DCI_F_PSDDR_MS
Y3   DDR_dq[25]   SSTL15_DCI_F_PSDDR_MS
Y4   DDR_dq[27]   SSTL15_DCI_F_PSDDR_MS
Y5   GND   GND
Y10   VCCO_13   POWER
Y14   IO_L8N_T1_34   NC
Y15   GND   GND
Y16   IO_L7P_T1_34   NC
Y17   IO_L7N_T1_34   NC
Y18   IO_L17P_T2_34   NC
Y19   IO_L17N_T2_34   NC
Y20   VCCO_34   POWER
[Package Model]   xc7z010_clg400
[Diff Pin]   inv_pin   vdiff   tdelay_typ   tdelay_min   tdelay_max
C2   B2   100mv   0   0   0
| DDR_dqs_p[0]   DIFF_SSTL15_T_DCI_F_PSDDR_P SSTL15_DCI_F_PSDDR_IN50_I
G2   F2   100mv   0   0   0
| DDR_dqs_p[1]   DIFF_SSTL15_T_DCI_F_PSDDR_P SSTL15_DCI_F_PSDDR_IN50_I
L2   M2   100mv   0   0   0
| DDR_ck_p   DIFF_SSTL15_F_PSDDR_P SSTL15_F_PSDDR
R2   T2   100mv   0   0   0
| DDR_dqs_p[2]   DIFF_SSTL15_T_DCI_F_PSDDR_P SSTL15_DCI_F_PSDDR_IN50_I
W5   W4   100mv   0   0   0
| DDR_dqs_p[3]   DIFF_SSTL15_T_DCI_F_PSDDR_P SSTL15_DCI_F_PSDDR_IN50_I
[Model Selector]   SSTL15_DCI_F_PSDDR_MS
SSTL15_DCI_F_PSDDR_IN40_I   Input
SSTL15_DCI_F_PSDDR_IN50_I   Input
SSTL15_DCI_F_PSDDR_IN60_I   Input
SSTL15_DCI_F_PSDDR_O   Output
[Define Package Model]   xc7z010_clg400
[Manufacturer]   Xilinx Inc.
[OEM]   Xilinx
[Description]   400 ball organic flip-chip
|[Number of Sections]   1
[Number of Pins]   265
[Pin Numbers]
|[Pin Name]  Net Number   Net Name   Net's All Pins
J9   | 1   VCCADC_0   J9
J11   | 2   VCCAUX   J11
   |L11
   |N9
   |N11
   |P10
   |R9
F11   | 3   VCCBATT_0   F11
G11   | 4   VCCBRAM   G11
   |H10
G13   | 5   VCCINT   G13
   |H12
   |J13
   |K12
   |L13
   |M12
   |N13
   |P12
   |R13
K6   | 6   VCCO_0   K6
N19   | 7   VCCO_34   N19
   |R15
   |T18
   |V14
   |W17
   |Y20
C19   | 8   VCCO_35   C19
   |F18
   |H14
   |J17
   |K20
   |M16
A3   | 9   VCCO_DDR_502   A3
   |D2
   |E5
   |G1
   |H4
   |L3
   |P2
   |R5
   |U1
   |V4
B6   | 10   VCCO_MIO0_500   B6
   |D7
A13   | 11   VCCO_MIO1_501   A13
   |B16
   |D12
   |E15
F8   | 12   VCCPAUX   F8
   |G9
   |H8
   |K8
   |M8
G7   | 13   VCCPINT   G7
   |J7
   |L7
   |N7
   |P8
   |R7
G8   | 14   VCCPLL   G8
F10   | 15   CCLK_0   F10
M6   | 16   CFGBVS_0   M6
R11   | 17   DONE_0   R11
M10   | 18   DXN_0   M10
M9   | 19   DXP_0   M9
R10   | 20   INIT_B_0   R10
R19   | 21   IO_0_34   R19
G14   | 22   IO_0_35   G14
T19   | 23   IO_25_34   T19
J15   | 24   IO_25_35   J15
B20   | 25   IO_L1N_T0_AD0N_35   B20
T10   | 26   IO_L1N_T0_D01_DIN_34   T10
C20   | 27   IO_L1P_T0_AD0P_35   C20
T11   | 28   IO_L1P_T0_D00_MOSI_34   T11
A20   | 29   IO_L2N_T0_AD8N_35   A20
U12   | 30   IO_L2N_T0_D03_34   U12
B19   | 31   IO_L2P_T0_AD8P_35   B19
T12   | 32   IO_L2P_T0_D02_34   T12
D18   | 33   IO_L3N_T0_DQS_AD1N_35   D18
V13   | 34   IO_L3N_T0_DQS_EMCCLK_34   V13
E17   | 35   IO_L3P_T0_DQS_AD1P_35   E17
U13   | 36   IO_L3P_T0_DQS_PUDC_B_34   U13
D20   | 37   IO_L4N_T0_35   D20
W13   | 38   IO_L4N_T0_D05_34   W13
D19   | 39   IO_L4P_T0_35   D19
V12   | 40   IO_L4P_T0_D04_34   V12
E19   | 41   IO_L5N_T0_AD9N_35   E19
T15   | 42   IO_L5N_T0_D07_34   T15
E18   | 43   IO_L5P_T0_AD9P_35   E18
T14   | 44   IO_L5P_T0_D06_34   T14
R14   | 45   IO_L6N_T0_D08_VREF_34   R14
F17   | 46   IO_L6N_T0_VREF_35   F17
F16   | 47   IO_L6P_T0_35   F16
P14   | 48   IO_L6P_T0_FCS_B_34   P14
M20   | 49   IO_L7N_T1_AD2N_35   M20
Y17   | 50   IO_L7N_T1_D10_34   Y17
M19   | 51   IO_L7P_T1_AD2P_35   M19
Y16   | 52   IO_L7P_T1_D09_34   Y16
M18   | 53   IO_L8N_T1_AD10N_35   M18
Y14   | 54   IO_L8N_T1_D12_34   Y14
M17   | 55   IO_L8P_T1_AD10P_35   M17
W14   | 56   IO_L8P_T1_D11_34   W14
L20   | 57   IO_L9N_T1_DQS_AD3N_35   L20
U17   | 58   IO_L9N_T1_DQS_D13_34   U17
T16   | 59   IO_L9P_T1_DQS_34   T16
L19   | 60   IO_L9P_T1_DQS_AD3P_35   L19
J19   | 61   IO_L10N_T1_AD11N_35   J19
W15   | 62   IO_L10N_T1_D15_34   W15
K19   | 63   IO_L10P_T1_AD11P_35   K19
V15   | 64   IO_L10P_T1_D14_34   V15
U15   | 65   IO_L11N_T1_SRCC_34   U15
L17   | 66   IO_L11N_T1_SRCC_35   L17
U14   | 67   IO_L11P_T1_SRCC_34   U14
L16   | 68   IO_L11P_T1_SRCC_35   L16
U19   | 69   IO_L12N_T1_MRCC_34   U19
K18   | 70   IO_L12N_T1_MRCC_35   K18
U18   | 71   IO_L12P_T1_MRCC_34   U18
K17   | 72   IO_L12P_T1_MRCC_35   K17
P19   | 73   IO_L13N_T2_MRCC_34   P19
H17   | 74   IO_L13N_T2_MRCC_35   H17
N18   | 75   IO_L13P_T2_MRCC_34   N18
H16   | 76   IO_L13P_T2_MRCC_35   H16
H18   | 77   IO_L14N_T2_AD4N_SRCC_35   H18
P20   | 78   IO_L14N_T2_SRCC_34   P20
J18   | 79   IO_L14P_T2_AD4P_SRCC_35   J18
N20   | 80   IO_L14P_T2_SRCC_34   N20
F20   | 81   IO_L15N_T2_DQS_AD12N_35   F20
U20   | 82   IO_L15N_T2_DQS_DOUT_CSO_B_34   U20
F19   | 83   IO_L15P_T2_DQS_AD12P_35   F19
T20   | 84   IO_L15P_T2_DQS_RDWR_B_34   T20
G18   | 85   IO_L16N_T2_35   G18
W20   | 86   IO_L16N_T2_A15_D31_34   W20
G17   | 87   IO_L16P_T2_35   G17
V20   | 88   IO_L16P_T2_CSI_B_34   V20
Y19   | 89   IO_L17N_T2_A13_D29_34   Y19
H20   | 90   IO_L17N_T2_AD5N_35   H20
Y18   | 91   IO_L17P_T2_A14_D30_34   Y18
J20   | 92   IO_L17P_T2_AD5P_35   J20
W16   | 93   IO_L18N_T2_A11_D27_34   W16
G20   | 94   IO_L18N_T2_AD13N_35   G20
V16   | 95   IO_L18P_T2_A12_D28_34   V16
G19   | 96   IO_L18P_T2_AD13P_35   G19
R17   | 97   IO_L19N_T3_A09_D25_VREF_34   R17
G15   | 98   IO_L19N_T3_VREF_35   G15
H15   | 99   IO_L19P_T3_35   H15
R16   | 100   IO_L19P_T3_A10_D26_34   R16
R18   | 101   IO_L20N_T3_A07_D23_34   R18
J14   | 102   IO_L20N_T3_AD6N_35   J14
T17   | 103   IO_L20P_T3_A08_D24_34   T17
K14   | 104   IO_L20P_T3_AD6P_35   K14
V18   | 105   IO_L21N_T3_DQS_A06_D22_34   V18
N16   | 106   IO_L21N_T3_DQS_AD14N_35   N16
V17   | 107   IO_L21P_T3_DQS_34   V17
N15   | 108   IO_L21P_T3_DQS_AD14P_35   N15
W19   | 109   IO_L22N_T3_A04_D20_34   W19
L15   | 110   IO_L22N_T3_AD7N_35   L15
W18   | 111   IO_L22P_T3_A05_D21_34   W18
L14   | 112   IO_L22P_T3_AD7P_35   L14
M15   | 113   IO_L23N_T3_35   M15
P18   | 114   IO_L23N_T3_A02_D18_34   P18
M14   | 115   IO_L23P_T3_35   M14
N17   | 116   IO_L23P_T3_A03_D19_34   N17
P16   | 117   IO_L24N_T3_A00_D16_34   P16
J16   | 118   IO_L24N_T3_AD15N_35   J16
P15   | 119   IO_L24P_T3_A01_D17_34   P15
K16   | 120   IO_L24P_T3_AD15P_35   K16
N6   | 121   M0_0   N6
R6   | 122   M1_0   R6
T6   | 123   M2_0   T6
L6   | 124   PROGRAM_B_0   L6
E7   | 125   PS_CLK_500   E7
N2   | 126   PS_DDR_A0_502   N2
K2   | 127   PS_DDR_A1_502   K2
M3   | 128   PS_DDR_A2_502   M3
K3   | 129   PS_DDR_A3_502   K3
M4   | 130   PS_DDR_A4_502   M4
L1   | 131   PS_DDR_A5_502   L1
L4   | 132   PS_DDR_A6_502   L4
K4   | 133   PS_DDR_A7_502   K4
K1   | 134   PS_DDR_A8_502   K1
J4   | 135   PS_DDR_A9_502   J4
F5   | 136   PS_DDR_A10_502   F5
G4   | 137   PS_DDR_A11_502   G4
E4   | 138   PS_DDR_A12_502   E4
D4   | 139   PS_DDR_A13_502   D4
F4   | 140   PS_DDR_A14_502   F4
L5   | 141   PS_DDR_BA0_502   L5
R4   | 142   PS_DDR_BA1_502   R4
J5   | 143   PS_DDR_BA2_502   J5
P5   | 144   PS_DDR_CAS_B_502   P5
N3   | 145   PS_DDR_CKE_502   N3
M2   | 146   PS_DDR_CKN_502   M2
L2   | 147   PS_DDR_CKP_502   L2
N1   | 148   PS_DDR_CS_B_502   N1
A1   | 149   PS_DDR_DM0_502   A1
F1   | 150   PS_DDR_DM1_502   F1
T1   | 151   PS_DDR_DM2_502   T1
Y1   | 152   PS_DDR_DM3_502   Y1
C3   | 153   PS_DDR_DQ0_502   C3
B3   | 154   PS_DDR_DQ1_502   B3
A2   | 155   PS_DDR_DQ2_502   A2
A4   | 156   PS_DDR_DQ3_502   A4
D3   | 157   PS_DDR_DQ4_502   D3
D1   | 158   PS_DDR_DQ5_502   D1
C1   | 159   PS_DDR_DQ6_502   C1
E1   | 160   PS_DDR_DQ7_502   E1
E2   | 161   PS_DDR_DQ8_502   E2
E3   | 162   PS_DDR_DQ9_502   E3
G3   | 163   PS_DDR_DQ10_502   G3
H3   | 164   PS_DDR_DQ11_502   H3
J3   | 165   PS_DDR_DQ12_502   J3
H2   | 166   PS_DDR_DQ13_502   H2
H1   | 167   PS_DDR_DQ14_502   H1
J1   | 168   PS_DDR_DQ15_502   J1
P1   | 169   PS_DDR_DQ16_502   P1
P3   | 170   PS_DDR_DQ17_502   P3
R3   | 171   PS_DDR_DQ18_502   R3
R1   | 172   PS_DDR_DQ19_502   R1
T4   | 173   PS_DDR_DQ20_502   T4
U4   | 174   PS_DDR_DQ21_502   U4
U2   | 175   PS_DDR_DQ22_502   U2
U3   | 176   PS_DDR_DQ23_502   U3
V1   | 177   PS_DDR_DQ24_502   V1
Y3   | 178   PS_DDR_DQ25_502   Y3
W1   | 179   PS_DDR_DQ26_502   W1
Y4   | 180   PS_DDR_DQ27_502   Y4
Y2   | 181   PS_DDR_DQ28_502   Y2
W3   | 182   PS_DDR_DQ29_502   W3
V2   | 183   PS_DDR_DQ30_502   V2
V3   | 184   PS_DDR_DQ31_502   V3
B2   | 185   PS_DDR_DQS_N0_502   B2
F2   | 186   PS_DDR_DQS_N1_502   F2
T2   | 187   PS_DDR_DQS_N2_502   T2
W4   | 188   PS_DDR_DQS_N3_502   W4
C2   | 189   PS_DDR_DQS_P0_502   C2
G2   | 190   PS_DDR_DQS_P1_502   G2
R2   | 191   PS_DDR_DQS_P2_502   R2
W5   | 192   PS_DDR_DQS_P3_502   W5
B4   | 193   PS_DDR_DRST_B_502   B4
N5   | 194   PS_DDR_ODT_502   N5
P4   | 195   PS_DDR_RAS_B_502   P4
H6   | 196   PS_DDR_VREF0_502   H6
P6   | 197   PS_DDR_VREF1_502   P6
G5   | 198   PS_DDR_VRN_502   G5
H5   | 199   PS_DDR_VRP_502   H5
M5   | 200   PS_DDR_WE_B_502   M5
E6   | 201   PS_MIO0_500   E6
A7   | 202   PS_MIO1_500   A7
B8   | 203   PS_MIO2_500   B8
D6   | 204   PS_MIO3_500   D6
B7   | 205   PS_MIO4_500   B7
A6   | 206   PS_MIO5_500   A6
A5   | 207   PS_MIO6_500   A5
D8   | 208   PS_MIO7_500   D8
D5   | 209   PS_MIO8_500   D5
B5   | 210   PS_MIO9_500   B5
E9   | 211   PS_MIO10_500   E9
C6   | 212   PS_MIO11_500   C6
D9   | 213   PS_MIO12_500   D9
E8   | 214   PS_MIO13_500   E8
C5   | 215   PS_MIO14_500   C5
C8   | 216   PS_MIO15_500   C8
A19   | 217   PS_MIO16_501   A19
E14   | 218   PS_MIO17_501   E14
B18   | 219   PS_MIO18_501   B18
D10   | 220   PS_MIO19_501   D10
A17   | 221   PS_MIO20_501   A17
F14   | 222   PS_MIO21_501   F14
B17   | 223   PS_MIO22_501   B17
D11   | 224   PS_MIO23_501   D11
A16   | 225   PS_MIO24_501   A16
F15   | 226   PS_MIO25_501   F15
A15   | 227   PS_MIO26_501   A15
D13   | 228   PS_MIO27_501   D13
C16   | 229   PS_MIO28_501   C16
C13   | 230   PS_MIO29_501   C13
C15   | 231   PS_MIO30_501   C15
E16   | 232   PS_MIO31_501   E16
A14   | 233   PS_MIO32_501   A14
D15   | 234   PS_MIO33_501   D15
A12   | 235   PS_MIO34_501   A12
F12   | 236   PS_MIO35_501   F12
A11   | 237   PS_MIO36_501   A11
A10   | 238   PS_MIO37_501   A10
E13   | 239   PS_MIO38_501   E13
C18   | 240   PS_MIO39_501   C18
D14   | 241   PS_MIO40_501   D14
C17   | 242   PS_MIO41_501   C17
E12   | 243   PS_MIO42_501   E12
A9   | 244   PS_MIO43_501   A9
F13   | 245   PS_MIO44_501   F13
B15   | 246   PS_MIO45_501   B15
D16   | 247   PS_MIO46_501   D16
B14   | 248   PS_MIO47_501   B14
B12   | 249   PS_MIO48_501   B12
C12   | 250   PS_MIO49_501   C12
B13   | 251   PS_MIO50_501   B13
B9   | 252   PS_MIO51_501   B9
C10   | 253   PS_MIO52_501   C10
C11   | 254   PS_MIO53_501   C11
E11   | 255   PS_MIO_VREF_501   E11
C7   | 256   PS_POR_B_500   C7
B10   | 257   PS_SRST_B_501   B10
F9   | 258   TCK_0   F9
G6   | 259   TDI_0   G6
F6   | 260   TDO_0   F6
J6   | 261   TMS_0   J6
L10   | 262   VN_0   L10
K9   | 263   VP_0   K9
K10   | 264   VREFN_0   K10
L9   | 265   VREFP_0   L9
[Model Data]
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[End Model Data]
[End Package Model]
| Models and submodels in the file (10): LVCMOS18_F_12_HR (I/O), LVCMOS18_S_8_PSMIO (I/O), LVCMOS25_F_8_HR (I/O), LVCMOS33_S_8_PSMIO (I/O), SSTL15_DCI_F_PSDDR_IN40_I (Input), SSTL15_DCI_F_PSDDR_IN50_I (Input), SSTL15_DCI_F_PSDDR_IN60_I (Input), SSTL15_DCI_F_PSDDR_O (Output), SSTL15_F_PSDDR (I/O), SSTL15_S_PSDDR (I/O)
